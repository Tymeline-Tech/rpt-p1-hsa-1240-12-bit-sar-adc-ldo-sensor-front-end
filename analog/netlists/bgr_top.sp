.SUBCKT bgr_top VDD VSS VREF IBIAS
* Instantiate core and startup (placeholders)
XCORE VDD VSS VREF IBIAS bgr_core
XSTARTUP VDD VSS STARTUP bgr_startup
.ENDS bgr_top
