.SUBCKT bgr_startup VDD VSS STARTUP
* No functional circuit possible without resistors/bipolars
.ENDS bgr_startup
