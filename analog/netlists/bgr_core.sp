.SUBCKT bgr_core VDD VSS VREF IBIAS
* No functional bandgap possible: resistors and bipolars required
.ENDS bgr_core
