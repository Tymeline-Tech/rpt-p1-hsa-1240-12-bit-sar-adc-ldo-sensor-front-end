.SUBCKT bgr_core VDD VSS VREF IBIAS
* No functional circuit possible without resistors/bipolars
.ENDS bgr_core
